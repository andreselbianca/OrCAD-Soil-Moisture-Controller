** Profile: "SCHEMATIC1-test"  [ D:\An 2-ETTI\Tehnici CAD-proiecte ORCAD\CAD2-PSpiceFiles\SCHEMATIC1\test.sim ]

** Creating circuit file "test.cir"
** WARNING: THIS AUTOMATICALLY GENERATED FILE MAY BE OVERWRITTEN BY SUBSEQUENT SIMULATIONS

*Libraries:
* Profile Libraries :
* Local Libraries :
* From [PSPICE NETLIST] section of C:\Users\bianca\cdssetup\OrCAD_PSpice\23.1.0\PSpice.ini file:
.lib "nom.lib"

*Analysis directives:
.DC LIN PARAM r 100k 600k 1k
.OPTIONS ADVCONV
.PROBE64 V(alias(*)) I(alias(*)) W(alias(*)) D(alias(*)) NOISE(alias(*))
.INC "..\SCHEMATIC1.net"

.END
